* LoRa 433MHz L-Match Network
.SUBCKT GeneralNetwork1 1 2 3
* 1 = Source Input
* 2 = Antenna Output
* 3 = Ground Reference
C1 1 3 23.8pF
L1 1 2 5.65nH
.ENDS
